#	module:	user_reg_model
#	gen_time:	2022-07-02 17:07:39 CST
block user_reg_model {
	bytes	4;
	endian	little;

	register GDMA_MISC_CONF_REG @0x0044 {
		bytes 4;
		field resvered1 @4 {
			bits	28	;
			access	ro	;
			reset	28'b0	;
		}
		field GDMA_AHBM_RST_INTER @3 {
			bits	1	;
			access	rw	;
			reset	1'b1	;
		}
		field GDMA_ARB_PRI_DIS @2 {
			bits	1	;
			access	rw	;
			reset	1'b0	;
		}
		field resvered0 @1 {
			bits	1	;
			access	ro	;
			reset	1'b0	;
		}
		field GDMA_CLK_EN @0 {
			bits	1	;
			access	rw	;
			reset	1'b1	;
		}
	}

	memory tx_ram @0x00ff {
		size	32;
		bits	128;
		access	rw;
	}

}

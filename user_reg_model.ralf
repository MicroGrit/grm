block user_reg_model {
	bytes	4;
	endian	little;

	register GDMA_MISC_CONF_REG @0x0044 {
		bytes 4;
		field resvered1 (resvered1) @4 {
			bits	28	;
			access	ro	;
			reset	28'b0	;
		}
		field gdma_ahbm_rst_inter (gdma_ahbm_rst_inter) @3 {
			bits	1	;
			access	rw	;
			reset	1'b1	;
		}
		field gdma_arb_pri_dis (gdma_arb_pri_dis) @2 {
			bits	1	;
			access	rw	;
			reset	1'b0	;
		}
		field resvered0 (resvered0) @1 {
			bits	1	;
			access	ro	;
			reset	1'b0	;
		}
		field gdma_clk_en (gdma_clk_en) @0 {
			bits	1	;
			access	rw	;
			reset	1'b1	;
		}
	}

	memory tx_ram @0x00ff {
		size	32;
		bits	128;
		access	rw;
	}

}
